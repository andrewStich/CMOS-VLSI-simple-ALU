ADE simulation setup
Run mode: Single Run, Sweeps and Corners
Tests:
  CPE_151:T_Gate_tb:1: CPE_151/T_Gate_tb/schematic, simulator spectre
