ADE simulation setup
Run mode: Single Run, Sweeps and Corners
Tests:
  CPE_151:MUX2_1_tb:1: CPE_151/MUX2_1_tb/schematic, simulator spectre
