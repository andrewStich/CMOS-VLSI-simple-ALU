ADE simulation setup
Run mode: Single Run, Sweeps and Corners
Tests:
  CPE_151:ALU_4bit_tb:1: CPE_151/ALU_4bit_tb/schematic, simulator spectre
