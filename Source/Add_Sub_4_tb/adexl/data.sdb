ADE simulation setup
Run mode: Single Run, Sweeps and Corners
Tests:
  CPE_151:Add_Sub_4_tb:1: CPE_151/Add_Sub_4_tb/schematic, simulator spectre
