ADE simulation setup
Run mode: Single Run, Sweeps and Corners
Tests:
  CPE_151:MUL_4x4_tb:1: CPE_151/MUL_4x4_tb/schematic, simulator spectre
