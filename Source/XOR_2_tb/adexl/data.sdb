ADE simulation setup
Run mode: Single Run, Sweeps and Corners
Tests:
  CPE_151:XOR_2_tb:1: CPE_151/XOR_2_tb/schematic, simulator spectre
