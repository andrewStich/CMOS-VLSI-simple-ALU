ADE simulation setup
Run mode: Single Run, Sweeps and Corners
Tests:
  CPE_151:L_R_shift_reg_tb:1: CPE_151/L_R_shift_reg_tb/schematic, simulator spectre
