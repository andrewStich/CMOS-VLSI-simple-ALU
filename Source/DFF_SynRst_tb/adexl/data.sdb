ADE simulation setup
Run mode: Single Run, Sweeps and Corners
Tests:
  CPE_151:DFF_SynRst_tb:1: CPE_151/DFF_SynRst_tb/schematic, simulator spectre
