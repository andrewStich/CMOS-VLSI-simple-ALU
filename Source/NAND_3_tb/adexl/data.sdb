ADE simulation setup
Run mode: Single Run, Sweeps and Corners
Tests:
  CPE_151:NAND_3_tb:1: CPE_151/NAND_3_tb/schematic, simulator spectre
