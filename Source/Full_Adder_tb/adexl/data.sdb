ADE simulation setup
Run mode: Single Run, Sweeps and Corners
Tests:
  CPE_151:Full_Adder_tb:1: CPE_151/Full_Adder_tb/schematic, simulator spectre
